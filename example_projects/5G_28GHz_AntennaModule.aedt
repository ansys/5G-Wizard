# Ansys Electronics Desktop project, version 2023.1
materials:
  ant_substrate: permittivity=2.39
  copper: permeability=0.999991 conductivity=58000000
  vacuum: permittivity=1
  pec: conductivity=1e+30

design 4x1_array1 (HFSS, HFSS Modal Network, model units mm)
options: Allow_Material_Override Save_Adaptive_support_files
variables:
  # Antenna
  patchW = 3.23mm
  patchL = 3.23mm
  patch2L = 2.86mm
  patch2W = 2.86mm
  top_patch_offset = 0.6mm
  subW = 5mm
  subL = 5mm
  bot_patch_offset = 0.49mm
  # Feed
  feed_Xpos = 1mm
  feed_Ypos = 1mm
  cond_T = 0.008mm
  feed_via_rad = 0.05mm
  feed_subH = 0.27mm
  antipad_rad = 0.15mm
  # Setup
  beamID = 1  # beam ID for controlling array
  p1_mag = 1W
  p2_mag = 2W
  post_beamID = 0
  post_BeamPair_PhaseOffset = 0deg
  post_UseBeamPair = false
  BeamPair_PhaseOffset = 0deg  # phase offset to apply to beam pair
  UseBeamPair = false  # boolearn to select if beam pair is used
datasets:
  ds_5_mag: (0, 1) (1, 1) (2, 1) (3, 1) (4, 1)
  ds_5_phase: (0, 0) (1, 40) (2, 80) (3, -40) (4, -80)
  ds_4_mag: (0, 0) (1, 0) (2, 0) (3, 0) (4, 0)
  ds_4_phase: (0, 0) (1, 0) (2, 0) (3, 0) (4, 0)
  ds_7_mag: (0, 1) (1, 1) (2, 1) (3, 1) (4, 1)
  ds_7_phase: (0, 0) (1, 60) (2, 120) (3, -60) (4, -120)
  ds_6_mag: (0, 0) (1, 0) (2, 0) (3, 0) (4, 0)
  ds_6_phase: (0, 0) (1, 0) (2, 0) (3, 0) (4, 0)
  ds_1_mag: (0, 1) (1, 1) (2, 1) (3, 1) (4, 1)
  ds_1_phase: (0, 0) (1, 0) (2, 0) (3, 0) (4, 0)
  ds_3_mag: (0, 1) (1, 1) (2, 1) (3, 1) (4, 1)
  ds_3_phase: (0, 0) (1, 20) (2, 40) (3, -20) (4, -40)
  ds_2_mag: (0, 0) (1, 0) (2, 0) (3, 0) (4, 0)
  ds_2_phase: (0, 0) (1, 0) (2, 0) (3, 0) (4, 0)
  ds_8_mag: (0, 0) (1, 0) (2, 0) (3, 0) (4, 0)
  ds_8_phase: (0, 0) (1, 0) (2, 0) (3, 0) (4, 0)
  ds_1_mag1: (0, 1) (1, 1) (2, 1) (3, 1) (4, 1) (5, 0)
  ds_1_phase1: (0, 0) (1, 0) (2, 0) (3, 0) (4, 0) (5, 0)
  ds_1_mag_bp: (0, 0) (1, 0) (2, 0) (3, 0) (4, 0)
  ds_1_phase_bp: (0, 0) (1, 0) (2, 0) (3, 0) (4, 0)
  ds_2_mag1: (0, 0) (1, 0) (2, 0) (3, 0) (4, 0) (5, 1)
  ds_2_phase1: (0, 0) (1, 0) (2, 0) (3, 0) (4, 0) (5, 0)
  ds_2_mag_bp: (0, 0) (1, 0) (2, 0) (3, 0) (4, 0)
  ds_2_phase_bp: (0, 0) (1, 0) (2, 0) (3, 0) (4, 0)
  ds_3_mag1: (0, 1) (1, 1) (2, 1) (3, 1) (4, 1) (5, 0)
  ds_3_phase1: (0, 0) (1, 20) (2, 40) (3, -40) (4, -20) (5, 0)
  ds_3_mag_bp: (0, 0) (1, 0) (2, 0) (3, 0) (4, 0)
  ds_3_phase_bp: (0, 0) (1, 0) (2, 0) (3, 0) (4, 0)
  ds_4_mag1: (0, 0) (1, 0) (2, 0) (3, 0) (4, 0) (5, 1)
  ds_4_phase1: (0, 0) (1, 0) (2, 0) (3, 0) (4, 0) (5, 0)
  ds_4_mag_bp: (0, 0) (1, 0) (2, 0) (3, 0) (4, 0)
  ds_4_phase_bp: (0, 0) (1, 0) (2, 0) (3, 0) (4, 0)
  ds_5_mag1: (0, 1) (1, 1) (2, 1) (3, 1) (4, 1) (5, 0)
  ds_5_phase1: (0, 0) (1, 40) (2, 80) (3, -80) (4, -40) (5, 0)
  ds_5_mag_bp: (0, 0) (1, 0) (2, 0) (3, 0) (4, 0)
  ds_5_phase_bp: (0, 0) (1, 0) (2, 0) (3, 0) (4, 0)
  ds_6_mag1: (0, 0) (1, 0) (2, 0) (3, 0) (4, 0) (5, 1)
  ds_6_phase1: (0, 0) (1, 0) (2, 0) (3, 0) (4, 0) (5, 0)
  ds_6_mag_bp: (0, 0) (1, 0) (2, 0) (3, 0) (4, 0)
  ds_6_phase_bp: (0, 0) (1, 0) (2, 0) (3, 0) (4, 0)
  ds_7_mag1: (0, 1) (1, 1) (2, 1) (3, 1) (4, 1) (5, 0)
  ds_7_phase1: (0, 0) (1, 60) (2, 120) (3, -120) (4, -60) (5, 0)
  ds_7_mag_bp: (0, 0) (1, 0) (2, 0) (3, 0) (4, 0)
  ds_7_phase_bp: (0, 0) (1, 0) (2, 0) (3, 0) (4, 0)
  ds_8_mag1: (0, 0) (1, 0) (2, 0) (3, 0) (4, 0) (5, 1)
  ds_8_phase1: (0, 0) (1, 0) (2, 0) (3, 0) (4, 0) (5, 0)
  ds_8_mag_bp: (0, 0) (1, 0) (2, 0) (3, 0) (4, 0)
  ds_8_phase_bp: (0, 0) (1, 0) (2, 0) (3, 0) (4, 0)
geometry:
  bot_patch [copper] = rectangle(corner=(-patchW/2, -patchL/2, 0mm), x_size=patchW, y_size=patchL)
  top_patch [copper] = rectangle(corner=(-patch2W/2, -patch2L/2, top_patch_offset), x_size=patch2W, y_size=patch2L)
  ant_sub [ant_substrate] = box(corner=(-subW/2, -subL/2, top_patch_offset), size=(subW, subL, -top_patch_offset-bot_patch_offset))
  [top_patch, bot_patch].rotate(axis=Z, angle=45deg)
  gnd_ant [copper] = object_from(ant_sub.face(-z))
  [top_patch, bot_patch].thicken(cond_T)
  feed_via_top [copper] = cylinder(axis=Z, base_centre=(feed_Xpos, feed_Ypos+feed_via_rad, 0mm), radius=feed_via_rad, height=-bot_patch_offset)
  gnd_ant.thicken(cond_T)
  Cylinder2 = cylinder(axis=Z, base_centre=(feed_Xpos, feed_Ypos+feed_via_rad, -bot_patch_offset), radius=antipad_rad, height=-cond_T)
  feed_via_top2 [copper] = feed_via_top.duplicate_mirror(point=(0mm, 0mm, 0.008mm), normal=(-1mm, 0mm, 0mm))
  Cylinder2_1 = Cylinder2.duplicate_mirror(point=(0mm, 0mm, 0.008mm), normal=(-1mm, 0mm, 0mm))
  gnd_ant.subtract(Cylinder2, Cylinder2_1)
  bot_sub = box(corner=(-subW/2, -subL/2, -bot_patch_offset), size=(subW, subL, -feed_subH-cond_T))
  gnd_bot = object_from(gnd_ant.face(2 of 6))
  gnd_bot.thicken(cond_T)
  Circle1 = circle(normal=Z, centre=(feed_Xpos, feed_Ypos+feed_via_rad, -bot_patch_offset), radius=antipad_rad)
  Circle1_1 = Circle1.duplicate_mirror(point=(0mm, 0mm, 0mm), normal=(1mm, 0mm, 0mm))
  bot_patch_1, bot_patch_2, bot_patch_3 [copper] = bot_patch.duplicate_along_line(step=(5mm, 0mm, 0mm), total=4)
  top_patch_1, top_patch_2, top_patch_3 [copper] = top_patch.duplicate_along_line(step=(5mm, 0mm, 0mm), total=4)
  ant_sub_1, ant_sub_2, ant_sub_3 = ant_sub.duplicate_along_line(step=(5mm, 0mm, 0mm), total=4)
  gnd_ant_1, gnd_ant_2, gnd_ant_3 = gnd_ant.duplicate_along_line(step=(5mm, 0mm, 0mm), total=4)
  feed_via_top_1, feed_via_top_2, feed_via_top_3 [copper] = feed_via_top.duplicate_along_line(step=(5mm, 0mm, 0mm), total=4)
  feed_via_top2_1, feed_via_top2_2, feed_via_top2_3 [copper] = feed_via_top2.duplicate_along_line(step=(5mm, 0mm, 0mm), total=4)
  bot_sub_1, bot_sub_2, bot_sub_3 = bot_sub.duplicate_along_line(step=(5mm, 0mm, 0mm), total=4)
  gnd_bot_1, gnd_bot_2, gnd_bot_3 = gnd_bot.duplicate_along_line(step=(5mm, 0mm, 0mm), total=4)
  Circle1_2, Circle1_3, Circle1_4 = Circle1.duplicate_along_line(step=(5mm, 0mm, 0mm), total=4)
  Circle1_1_1, Circle1_1_2, Circle1_1_3 = Circle1_1.duplicate_along_line(step=(5mm, 0mm, 0mm), total=4)
  RadiatingSurface [vacuum] = region(absolute_offset=3.5714286mm on all sides)
  ant_sub.unite(ant_sub_1, ant_sub_2, ant_sub_3)
  bot_sub.unite(bot_sub_1, bot_sub_2, bot_sub_3)
  gnd_ant.unite(gnd_ant_1, gnd_ant_2, gnd_ant_3)
  gnd_ant.unite(bot_sub)
  gnd_ant.unite(gnd_bot, gnd_bot_1, gnd_bot_2, gnd_bot_3)
  5mm_Surface [non-model] = rectangle(corner=(-2.5mm, -2.5mm, 0.6mm), x_size=20mm, y_size=5mm)
  5mm_Surface.move(0mm, 0mm, 5mm)
  5mm_Surface.move_edges(MoveAlongNormalFlag=true OffsetDistance=20mm EdgesToMove=5mm_Surface.edge(all 4))
  20mm_Surface [non-model] = rectangle(corner=(-2.5mm, -2.5mm, 0.6mm), x_size=20mm, y_size=5mm)
  20mm_Surface.move(0mm, 0mm, 20mm)
  20mm_Surface.move_edges(MoveAlongNormalFlag=true OffsetDistance=60mm EdgesToMove=20mm_Surface.edge(all 4))
  50mm_Surface [non-model] = rectangle(corner=(-2.5mm, -2.5mm, 0.6mm), x_size=20mm, y_size=5mm)
  50mm_Surface.move(0mm, 0mm, 50mm)
  50mm_Surface.move_edges(MoveAlongNormalFlag=true OffsetDistance=100mm EdgesToMove=50mm_Surface.edge(all 4))
  coordinate_system RelativeCS1 = origin=(1mm, 1.05mm, -0.49mm) x=(1mm, 0mm, 0mm) y=(0mm, 1mm, 0mm)
  coordinate_system RelativeCS2 = origin=(-2mm, 0mm, 0mm) x=(1mm, 0mm, 0mm) y=(0mm, 1mm, 0mm) in RelativeCS1
  coordinate_system RelativeCS3 = origin=(6mm, 1.05mm, -0.49mm) x=(1mm, 0mm, 0mm) y=(0mm, 1mm, 0mm)
  coordinate_system RelativeCS4 = origin=(-2mm, 0mm, 0mm) x=(1mm, 0mm, 0mm) y=(0mm, 1mm, 0mm) in RelativeCS3
  coordinate_system RelativeCS5 = origin=(7mm, 0mm, 0mm) x=(1mm, 0mm, 0mm) y=(0mm, 1mm, 0mm) in RelativeCS4
  coordinate_system RelativeCS6 = origin=(-2mm, 0mm, 0mm) x=(1mm, 0mm, 0mm) y=(0mm, 1mm, 0mm) in RelativeCS5
  coordinate_system RelativeCS7 = origin=(7mm, 0mm, 0mm) x=(1mm, 0mm, 0mm) y=(0mm, 1mm, 0mm) in RelativeCS6
  coordinate_system RelativeCS8 = origin=(-2mm, 0mm, 0mm) x=(1mm, 0mm, 0mm) y=(0mm, 1mm, 0mm) in RelativeCS7
boundaries and excitations:
  Open1: Radiation Objects=RadiatingSurface
  1: Lumped Port Objects=Circle1 LumpedPortType=Modal Modes{Mode1{IntLine{(1, 0.9, -0.49) -> (1, 1, -0.49)} CharImp=Zpi RenormImp=50ohm}} Impedance=50ohm
  2: Lumped Port Objects=Circle1_1 LumpedPortType=Modal Modes{Mode1{IntLine{(-1, 0.9, -0.49) -> (-1, 1, -0.49)} CharImp=Zpi RenormImp=50ohm}} Impedance=50ohm
  3: Lumped Port Objects=Circle1_2 LumpedPortType=Modal Modes{Mode1{IntLine{(6, 0.9, -0.49) -> (6, 1, -0.49)} CharImp=Zpi RenormImp=50ohm}} Impedance=50ohm
  4: Lumped Port Objects=Circle1_1_1 LumpedPortType=Modal Modes{Mode1{IntLine{(4, 0.9, -0.49) -> (4, 1, -0.49)} CharImp=Zpi RenormImp=50ohm}} Impedance=50ohm
  5: Lumped Port Objects=Circle1_3 LumpedPortType=Modal Modes{Mode1{IntLine{(11, 0.9, -0.49) -> (11, 1, -0.49)} CharImp=Zpi RenormImp=50ohm}} Impedance=50ohm
  6: Lumped Port Objects=Circle1_1_2 LumpedPortType=Modal Modes{Mode1{IntLine{(9, 0.9, -0.49) -> (9, 1, -0.49)} CharImp=Zpi RenormImp=50ohm}} Impedance=50ohm
  7: Lumped Port Objects=Circle1_4 LumpedPortType=Modal Modes{Mode1{IntLine{(16, 0.9, -0.49) -> (16, 1, -0.49)} CharImp=Zpi RenormImp=50ohm}} Impedance=50ohm
  8: Lumped Port Objects=Circle1_1_3 LumpedPortType=Modal Modes{Mode1{IntLine{(14, 0.9, -0.49) -> (14, 1, -0.49)} CharImp=Zpi RenormImp=50ohm}} Impedance=50ohm
setups:
  Setup1: HfssDriven Frequency=28GHz MaxDeltaS=0.02 MaximumPasses=20 MinimumPasses=1 MinimumConvergedPasses=1 PercentRefinement=30 BasisOrder=-1 PortAccuracy=2 DrivenSolverType="Direct Solver" VariableFlagsForDerivatives(1, 1, 1, 1, 1, 1)
    sweep Sweep: 26.5GHz to 29.5GHz step 0.5GHz; Type=Discrete SaveFields
source amplitudes:
  1:1: 1 0deg
  2:1, 3:1, 4:1, 5:1, 6:1, 7:1, 8:1: 0 0deg
radiation setups:
  3D: Infinite Sphere Theta=-180deg..180deg step 2deg Phi=0deg..180deg step 2deg
  Elevation: Infinite Sphere Theta=-180deg..180deg step 1deg Phi=0deg..90deg step 90deg
  Azimuth: Infinite Sphere Theta=90deg..90deg step 0deg Phi=-180deg..180deg step 1deg
  RadSetup_FF: Infinite Sphere Theta=0deg..180deg step 5deg Phi=-180deg..180deg step 5deg
output variables:
  Prad = 10*log10(AcceptedPower/1e-3)
field calculator expressions:
  Pz = Fundamental_Quantity(0) | <Hx,Hy,Hz> | Conj | Cross | 0.5 | * | ScalarZ | Real
reports:
  rE Plot 3: abs(rETotal) vs Theta on Setup1 : Sweep, 3D [Phi=0deg Freq=28.5GHz]
  rE Plot 4: abs(rETotal) vs Theta, Phi on Setup1 : LastAdaptive, 3D [Freq=28GHz]
  rE Plot 5: dB(RealizedGainTotal) vs Theta on Setup1 : Sweep, 3D [Phi=0deg,90deg Freq=28GHz]
  CDF: max(dB(RealizedGainTotal)) vs Freq on Setup1 : LastAdaptive, 3D [post_beamID=all Freq=28GHz Phi=all Theta=all]; markers MX1 at x=0.042
  EnvelopePattern3D_F_28.0GHz: max(dB(RealizedGainTotal)) vs Theta, Phi on Setup1 : LastAdaptive, 3D [post_beamID=all Freq=28GHz]
  BeamID_for_Max_F_28.0GHz: XAtYMax(dB(RealizedGainTotal)) vs Theta, Phi on Setup1 : LastAdaptive, 3D [post_beamID=all Freq=28GHz]

design 4x1_array3 (HFSS, HFSS Modal Network, model units mm)
options: Allow_Material_Override Save_Adaptive_support_files
variables:
  # Antenna
  patchW = 3.23mm
  patchL = 3.23mm
  patch2L = 2.86mm
  patch2W = 2.86mm
  top_patch_offset = 0.6mm
  subW = 5mm
  subL = 5mm
  bot_patch_offset = 0.49mm
  # Feed
  feed_Xpos = 1mm
  feed_Ypos = 1mm
  cond_T = 0.008mm
  feed_via_rad = 0.05mm
  feed_subH = 0.27mm
  antipad_rad = 0.15mm
  # Setup
  test = 1mm
  test2 = 1mm
  test3 = 1mm
  test3_post = 1mm
  beamID = 0  # beam ID for controlling array
  post_test3_post = 1mm
  post_beamID = 0
  post_BeamPair_PhaseOffset = 0deg
  post_UseBeamPair = true
datasets:
  ds_5_mag: (0, 1) (1, 0)
  ds_5_phase: (0, 0) (1, 0)
  ds_6_mag: (0, 0) (1, 0)
  ds_6_phase: (0, 0) (1, 0)
  ds_13_mag: (0, 0) (1, 1)
  ds_13_phase: (0, 0) (1, 0)
  ds_14_mag: (0, 0) (1, 0)
  ds_14_phase: (0, 0) (1, 0)
  ds_5_mag1: (0, 1) (1, 1) (2, 1) (3, 1) (4, 1) (5, 0)
  ds_5_phase1: (0, 0) (1, 40) (2, 80) (3, -80) (4, -40) (5, 0)
  ds_5_mag_bp: (0, 0) (1, 0) (2, 0) (3, 0) (4, 0) (5, 0)
  ds_5_phase_bp: (0, 0) (1, 0) (2, 0) (3, 0) (4, 0) (5, 0)
geometry:
  bot_patch = rectangle(corner=(-patchW/2, -patchL/2, 0mm), x_size=patchW, y_size=patchL)
  top_patch = rectangle(corner=(-patch2W/2, -patch2L/2, top_patch_offset), x_size=patch2W, y_size=patch2L)
  ant_sub [ant_substrate] = box(corner=(-subW/2, -subL/2, top_patch_offset), size=(subW, subL, -top_patch_offset-bot_patch_offset))
  [top_patch, bot_patch].rotate(axis=Z, angle=45deg)
  gnd_ant [copper] = object_from(ant_sub.face(-z))
  [top_patch, bot_patch].thicken(cond_T)
  feed_via_top = cylinder(axis=Z, base_centre=(feed_Xpos, feed_Ypos+feed_via_rad, 0mm), radius=feed_via_rad, height=-bot_patch_offset)
  gnd_ant.thicken(cond_T)
  Cylinder2 = cylinder(axis=Z, base_centre=(feed_Xpos, feed_Ypos+feed_via_rad, -bot_patch_offset), radius=antipad_rad, height=-cond_T)
  feed_via_top2 = feed_via_top.duplicate_mirror(point=(0mm, 0mm, 0.008mm), normal=(-1mm, 0mm, 0mm))
  Cylinder2_1 = Cylinder2.duplicate_mirror(point=(0mm, 0mm, 0.008mm), normal=(-1mm, 0mm, 0mm))
  gnd_ant.subtract(Cylinder2, Cylinder2_1)
  bot_sub = box(corner=(-subW/2, -subL/2, -bot_patch_offset), size=(subW, subL, -feed_subH-cond_T))
  gnd_bot = object_from(gnd_ant.face(2 of 6))
  gnd_bot.thicken(cond_T)
  Circle1 = circle(normal=Z, centre=(feed_Xpos, feed_Ypos+feed_via_rad, -bot_patch_offset), radius=antipad_rad)
  Circle1_1 = Circle1.duplicate_mirror(point=(0mm, 0mm, 0mm), normal=(1mm, 0mm, 0mm))
  bot_patch_2 [copper] = bot_patch.duplicate_along_line(step=(5mm, 0mm, 0mm), total=4)  # copies kept: 2
  top_patch_2 [copper] = top_patch.duplicate_along_line(step=(5mm, 0mm, 0mm), total=4)  # copies kept: 2
  ant_sub_1, ant_sub_2, ant_sub_3 = ant_sub.duplicate_along_line(step=(5mm, 0mm, 0mm), total=4)
  gnd_ant_1, gnd_ant_2, gnd_ant_3 = gnd_ant.duplicate_along_line(step=(5mm, 0mm, 0mm), total=4)
  feed_via_top_2 [copper] = feed_via_top.duplicate_along_line(step=(5mm, 0mm, 0mm), total=4)  # copies kept: 2
  feed_via_top2_2 [copper] = feed_via_top2.duplicate_along_line(step=(5mm, 0mm, 0mm), total=4)  # copies kept: 2
  bot_sub_1, bot_sub_2, bot_sub_3 = bot_sub.duplicate_along_line(step=(5mm, 0mm, 0mm), total=4)
  gnd_bot_1, gnd_bot_2, gnd_bot_3 = gnd_bot.duplicate_along_line(step=(5mm, 0mm, 0mm), total=4)
  Circle1_3 = Circle1.duplicate_along_line(step=(5mm, 0mm, 0mm), total=4)  # copies kept: 2
  Circle1_1_2 = Circle1_1.duplicate_along_line(step=(5mm, 0mm, 0mm), total=4)  # copies kept: 2
  RadiatingSurface [vacuum] = region(absolute_offset=3.5714286mm on all sides)
  ant_sub.unite(ant_sub_1, ant_sub_2, ant_sub_3)
  bot_sub.unite(bot_sub_1, bot_sub_2, bot_sub_3)
  gnd_ant.unite(gnd_ant_1, gnd_ant_2, gnd_ant_3)
  gnd_ant.unite(bot_sub)
  gnd_ant.unite(gnd_bot, gnd_bot_1, gnd_bot_2, gnd_bot_3)
  5mm_Surface [non-model] = rectangle(corner=(-2.5mm, -2.5mm, 0.6mm), x_size=20mm, y_size=5mm)
  5mm_Surface.move(0mm, 0mm, 5mm)
  5mm_Surface.move_edges(MoveAlongNormalFlag=true OffsetDistance=20mm EdgesToMove=5mm_Surface.edge(all 4))
  20mm_Surface [non-model] = rectangle(corner=(-2.5mm, -2.5mm, 0.6mm), x_size=20mm, y_size=5mm)
  20mm_Surface.move(0mm, 0mm, 20mm)
  20mm_Surface.move_edges(MoveAlongNormalFlag=true OffsetDistance=60mm EdgesToMove=20mm_Surface.edge(all 4))
  50mm_Surface [non-model] = rectangle(corner=(-2.5mm, -2.5mm, 0.6mm), x_size=20mm, y_size=5mm)
  50mm_Surface.move(0mm, 0mm, 50mm)
  50mm_Surface.move_edges(MoveAlongNormalFlag=true OffsetDistance=100mm EdgesToMove=50mm_Surface.edge(all 4))
  [bot_patch, top_patch].delete()
  ant_sub_4 [ant_substrate] = ant_sub.duplicate_mirror(point=(17.5mm, 0mm, -0.776mm), normal=(0mm, 0mm, -1mm))
  gnd_ant_4 [copper] = gnd_ant.duplicate_mirror(point=(17.5mm, 0mm, -0.776mm), normal=(0mm, 0mm, -1mm))
  [feed_via_top, feed_via_top2, Circle1, Circle1_1].delete()
  bot_patch_2_1 [copper] = bot_patch_2.duplicate_mirror(point=(17.5mm, 0mm, -0.776mm), normal=(0mm, 0mm, -1mm))
  top_patch_2_1 [copper] = top_patch_2.duplicate_mirror(point=(17.5mm, 0mm, -0.776mm), normal=(0mm, 0mm, -1mm))
  feed_via_top_2_1 [copper] = feed_via_top_2.duplicate_mirror(point=(17.5mm, 0mm, -0.776mm), normal=(0mm, 0mm, -1mm))
  feed_via_top2_2_1 [copper] = feed_via_top2_2.duplicate_mirror(point=(17.5mm, 0mm, -0.776mm), normal=(0mm, 0mm, -1mm))
  Circle1_3_1 = Circle1_3.duplicate_mirror(point=(17.5mm, 0mm, -0.776mm), normal=(0mm, 0mm, -1mm))
  Circle1_1_2_1 = Circle1_1_2.duplicate_mirror(point=(17.5mm, 0mm, -0.776mm), normal=(0mm, 0mm, -1mm))
boundaries and excitations:
  Open1: Radiation Objects=RadiatingSurface
  5: Lumped Port Objects=Circle1_3 LumpedPortType=Modal Modes{Mode1{IntLine{(11, 0.9, -0.49) -> (11, 1, -0.49)} CharImp=Zpi RenormImp=50ohm}} Impedance=50ohm
  6: Lumped Port Objects=Circle1_1_2 LumpedPortType=Modal Modes{Mode1{IntLine{(9, 0.9, -0.49) -> (9, 1, -0.49)} CharImp=Zpi RenormImp=50ohm}} Impedance=50ohm
  7: Lumped Port Objects=Circle1_3_1 LumpedPortType=Modal Modes{Mode1{IntLine{(11, 0.9, -1.062) -> (11, 1, -1.062)} CharImp=Zpi RenormImp=50ohm}} Impedance=50ohm
  8: Lumped Port Objects=Circle1_1_2_1 LumpedPortType=Modal Modes{Mode1{IntLine{(9, 0.9, -1.062) -> (9, 1, -1.062)} CharImp=Zpi RenormImp=50ohm}} Impedance=50ohm
setups:
  Setup1: HfssDriven Frequency=28GHz MaxDeltaS=0.02 MaximumPasses=10 MinimumPasses=1 MinimumConvergedPasses=1 PercentRefinement=30 BasisOrder=-1 PortAccuracy=2 DrivenSolverType="Direct Solver" VariableFlagsForDerivatives(1, 1, 1, 1, 1, 1)
    sweep Sweep: 26.5GHz to 29.5GHz step 1GHz; disabled Type=Discrete SaveFields
source amplitudes:
  5:1: pwl(ds_5_mag,beamID) pwl(ds_5_phase,beamID) deg
  6:1: pwl(ds_6_mag,beamID) pwl(ds_6_phase,beamID) deg
  7:1: pwl(ds_13_mag,beamID) pwl(ds_13_phase,beamID) deg
  8:1: pwl(ds_14_mag,beamID) pwl(ds_14_phase,beamID) deg
radiation setups:
  3D: Infinite Sphere Theta=0deg..180deg step 2deg Phi=-180deg..180deg step 2deg
  Elevation: Infinite Sphere Theta=-180deg..180deg step 1deg Phi=0deg..90deg step 90deg
  Azimuth: Infinite Sphere Theta=90deg..90deg step 0deg Phi=-180deg..180deg step 1deg
output variables:
  Prad = 10*log10(AcceptedPower/1e-3)
field calculator expressions:
  Pz = Fundamental_Quantity(0) | <Hx,Hy,Hz> | Conj | Cross | 0.5 | * | ScalarZ | Real

design 4x1_array2 (HFSS, HFSS Modal Network, model units mm)
options: Allow_Material_Override Save_Adaptive_support_files
variables:
  # Antenna
  patchW = 3.77mm
  patchL = 3.33mm
  patch2L = 2.86mm
  patch2W = 2.86mm
  top_patch_offset = 0.6mm
  subW = 5mm
  subL = 5mm
  bot_patch_offset = 0.49mm
  # Feed
  feed_Xpos = 1mm
  feed_Ypos = 1mm
  cond_T = 0.008mm
  feed_via_rad = 0.05mm
  feed_subH = 0.27mm
  antipad_rad = 0.15mm
  # Setup
  beamID = 0  # beam ID for controlling array
  p1_mag = 1W
  p2_mag = 2W
  post_beamID = 0
  post_BeamPair_PhaseOffset = 0deg
  post_UseBeamPair = true
  BeamPair_PhaseOffset = 0deg  # phase offset to apply to beam pair
  UseBeamPair = true  # boolearn to select if beam pair is used
datasets:
  ds_5_mag: (0, 1) (1, 1) (2, 1) (3, 1) (4, 1)
  ds_5_phase: (0, 0) (1, 40) (2, 80) (3, -40) (4, -80)
  ds_4_mag: (0, 0) (1, 0) (2, 0) (3, 0) (4, 0)
  ds_4_phase: (0, 0) (1, 0) (2, 0) (3, 0) (4, 0)
  ds_7_mag: (0, 1) (1, 1) (2, 1) (3, 1) (4, 1)
  ds_7_phase: (0, 0) (1, 60) (2, 120) (3, -60) (4, -120)
  ds_6_mag: (0, 0) (1, 0) (2, 0) (3, 0) (4, 0)
  ds_6_phase: (0, 0) (1, 0) (2, 0) (3, 0) (4, 0)
  ds_1_mag: (0, 1) (1, 1) (2, 1) (3, 1) (4, 1)
  ds_1_phase: (0, 0) (1, 0) (2, 0) (3, 0) (4, 0)
  ds_3_mag: (0, 1) (1, 1) (2, 1) (3, 1) (4, 1)
  ds_3_phase: (0, 0) (1, 20) (2, 40) (3, -20) (4, -40)
  ds_2_mag: (0, 0) (1, 0) (2, 0) (3, 0) (4, 0)
  ds_2_phase: (0, 0) (1, 0) (2, 0) (3, 0) (4, 0)
  ds_8_mag: (0, 0) (1, 0) (2, 0) (3, 0) (4, 0)
  ds_8_phase: (0, 0) (1, 0) (2, 0) (3, 0) (4, 0)
  ds_1_mag1: (0, 1) (1, 1) (2, 1) (3, 1) (4, 1) (5, 0)
  ds_1_phase1: (0, 0) (1, 0) (2, 0) (3, 0) (4, 0) (5, 0)
  ds_1_mag_bp: (0, 0) (1, 0) (2, 0) (3, 0) (4, 0)
  ds_1_phase_bp: (0, 0) (1, 0) (2, 0) (3, 0) (4, 0)
  ds_2_mag1: (0, 0) (1, 0) (2, 0) (3, 0) (4, 0) (5, 1)
  ds_2_phase1: (0, 0) (1, 0) (2, 0) (3, 0) (4, 0) (5, 0)
  ds_2_mag_bp: (0, 0) (1, 0) (2, 0) (3, 0) (4, 0)
  ds_2_phase_bp: (0, 0) (1, 0) (2, 0) (3, 0) (4, 0)
  ds_3_mag1: (0, 1) (1, 1) (2, 1) (3, 1) (4, 1) (5, 0)
  ds_3_phase1: (0, 0) (1, 20) (2, 40) (3, -40) (4, -20) (5, 0)
  ds_3_mag_bp: (0, 0) (1, 0) (2, 0) (3, 0) (4, 0)
  ds_3_phase_bp: (0, 0) (1, 0) (2, 0) (3, 0) (4, 0)
  ds_4_mag1: (0, 0) (1, 0) (2, 0) (3, 0) (4, 0) (5, 1)
  ds_4_phase1: (0, 0) (1, 0) (2, 0) (3, 0) (4, 0) (5, 0)
  ds_4_mag_bp: (0, 0) (1, 0) (2, 0) (3, 0) (4, 0)
  ds_4_phase_bp: (0, 0) (1, 0) (2, 0) (3, 0) (4, 0)
  ds_5_mag1: (0, 1) (1, 1) (2, 1) (3, 1) (4, 1) (5, 0)
  ds_5_phase1: (0, 0) (1, 40) (2, 80) (3, -80) (4, -40) (5, 0)
  ds_5_mag_bp: (0, 0) (1, 0) (2, 0) (3, 0) (4, 0)
  ds_5_phase_bp: (0, 0) (1, 0) (2, 0) (3, 0) (4, 0)
  ds_6_mag1: (0, 0) (1, 0) (2, 0) (3, 0) (4, 0) (5, 1)
  ds_6_phase1: (0, 0) (1, 0) (2, 0) (3, 0) (4, 0) (5, 0)
  ds_6_mag_bp: (0, 0) (1, 0) (2, 0) (3, 0) (4, 0)
  ds_6_phase_bp: (0, 0) (1, 0) (2, 0) (3, 0) (4, 0)
  ds_7_mag1: (0, 1) (1, 1) (2, 1) (3, 1) (4, 1) (5, 0)
  ds_7_phase1: (0, 0) (1, 60) (2, 120) (3, -120) (4, -60) (5, 0)
  ds_7_mag_bp: (0, 0) (1, 0) (2, 0) (3, 0) (4, 0)
  ds_7_phase_bp: (0, 0) (1, 0) (2, 0) (3, 0) (4, 0)
  ds_8_mag1: (0, 0) (1, 0) (2, 0) (3, 0) (4, 0) (5, 1)
  ds_8_phase1: (0, 0) (1, 0) (2, 0) (3, 0) (4, 0) (5, 0)
  ds_8_mag_bp: (0, 0) (1, 0) (2, 0) (3, 0) (4, 0)
  ds_8_phase_bp: (0, 0) (1, 0) (2, 0) (3, 0) (4, 0)
geometry:
  bot_patch [copper] = rectangle(corner=(-patchW/2, -patchL/2, 0mm), x_size=patchW, y_size=patchL)
  top_patch [copper] = rectangle(corner=(-patch2W/2, -patch2L/2, top_patch_offset), x_size=patch2W, y_size=patch2L)
  ant_sub [ant_substrate] = box(corner=(-subW/2, -subL/2, top_patch_offset), size=(subW, subL, -top_patch_offset-bot_patch_offset))
  [top_patch, bot_patch].rotate(axis=Z, angle=45deg)
  gnd_ant [copper] = object_from(ant_sub.face(-z))
  [top_patch, bot_patch].thicken(cond_T)
  feed_via_top [copper] = cylinder(axis=Z, base_centre=(feed_Xpos, feed_Ypos+feed_via_rad, 0mm), radius=feed_via_rad, height=-bot_patch_offset)
  gnd_ant.thicken(cond_T)
  Cylinder2 = cylinder(axis=Z, base_centre=(feed_Xpos, feed_Ypos+feed_via_rad, -bot_patch_offset), radius=antipad_rad, height=-cond_T)
  feed_via_top2 [copper] = feed_via_top.duplicate_mirror(point=(0mm, 0mm, 0.008mm), normal=(-1mm, 0mm, 0mm))
  Cylinder2_1 = Cylinder2.duplicate_mirror(point=(0mm, 0mm, 0.008mm), normal=(-1mm, 0mm, 0mm))
  gnd_ant.subtract(Cylinder2, Cylinder2_1)
  bot_sub = box(corner=(-subW/2, -subL/2, -bot_patch_offset), size=(subW, subL, -feed_subH-cond_T))
  gnd_bot = object_from(gnd_ant.face(2 of 6))
  gnd_bot.thicken(cond_T)
  Circle1 = circle(normal=Z, centre=(feed_Xpos, feed_Ypos+feed_via_rad, -bot_patch_offset), radius=antipad_rad)
  Circle1_1 = Circle1.duplicate_mirror(point=(0mm, 0mm, 0mm), normal=(1mm, 0mm, 0mm))
  bot_patch_1, bot_patch_2, bot_patch_3 [copper] = bot_patch.duplicate_along_line(step=(5mm, 0mm, 0mm), total=4)
  top_patch_1, top_patch_2, top_patch_3 [copper] = top_patch.duplicate_along_line(step=(5mm, 0mm, 0mm), total=4)
  ant_sub_1, ant_sub_2, ant_sub_3 = ant_sub.duplicate_along_line(step=(5mm, 0mm, 0mm), total=4)
  gnd_ant_1, gnd_ant_2, gnd_ant_3 = gnd_ant.duplicate_along_line(step=(5mm, 0mm, 0mm), total=4)
  feed_via_top_1, feed_via_top_2, feed_via_top_3 [copper] = feed_via_top.duplicate_along_line(step=(5mm, 0mm, 0mm), total=4)
  feed_via_top2_1, feed_via_top2_2, feed_via_top2_3 [copper] = feed_via_top2.duplicate_along_line(step=(5mm, 0mm, 0mm), total=4)
  bot_sub_1, bot_sub_2, bot_sub_3 = bot_sub.duplicate_along_line(step=(5mm, 0mm, 0mm), total=4)
  gnd_bot_1, gnd_bot_2, gnd_bot_3 = gnd_bot.duplicate_along_line(step=(5mm, 0mm, 0mm), total=4)
  Circle1_2, Circle1_3, Circle1_4 = Circle1.duplicate_along_line(step=(5mm, 0mm, 0mm), total=4)
  Circle1_1_1, Circle1_1_2, Circle1_1_3 = Circle1_1.duplicate_along_line(step=(5mm, 0mm, 0mm), total=4)
  RadiatingSurface [vacuum] = region(absolute_offset=3.5714286mm on all sides)
  ant_sub.unite(ant_sub_1, ant_sub_2, ant_sub_3)
  bot_sub.unite(bot_sub_1, bot_sub_2, bot_sub_3)
  gnd_ant.unite(gnd_ant_1, gnd_ant_2, gnd_ant_3)
  gnd_ant.unite(bot_sub)
  gnd_ant.unite(gnd_bot, gnd_bot_1, gnd_bot_2, gnd_bot_3)
  5mm_Surface [non-model] = rectangle(corner=(-2.5mm, -2.5mm, 0.6mm), x_size=20mm, y_size=5mm)
  5mm_Surface.move(0mm, 0mm, 5mm)
  5mm_Surface.move_edges(MoveAlongNormalFlag=true OffsetDistance=20mm EdgesToMove=5mm_Surface.edge(all 4))
  20mm_Surface [non-model] = rectangle(corner=(-2.5mm, -2.5mm, 0.6mm), x_size=20mm, y_size=5mm)
  20mm_Surface.move(0mm, 0mm, 20mm)
  20mm_Surface.move_edges(MoveAlongNormalFlag=true OffsetDistance=60mm EdgesToMove=20mm_Surface.edge(all 4))
  50mm_Surface [non-model] = rectangle(corner=(-2.5mm, -2.5mm, 0.6mm), x_size=20mm, y_size=5mm)
  50mm_Surface.move(0mm, 0mm, 50mm)
  50mm_Surface.move_edges(MoveAlongNormalFlag=true OffsetDistance=100mm EdgesToMove=50mm_Surface.edge(all 4))
  coordinate_system nearfield_cs = origin=(7.5mm, 0mm, 5.6mm) x=(0mm, 1mm, 0mm) y=(-1mm, 0mm, 0mm)
  25mm_Surface [non-model] = rectangle(corner=(-2.5mm, -2.5mm, 0.6mm), x_size=20mm, y_size=5mm) in nearfield_cs
  25mm_Surface.move(0mm, 0mm, 25mm) in nearfield_cs
  25mm_Surface.move_edges(MoveAlongNormalFlag=true OffsetDistance=80mm EdgesToMove=25mm_Surface.edge(all 4)) in nearfield_cs
boundaries and excitations:
  Open1: Radiation Objects=RadiatingSurface
  1: Lumped Port Objects=Circle1 LumpedPortType=Modal Modes{Mode1{IntLine{(1, 0.9, -0.49) -> (1, 1, -0.49)} CharImp=Zpi RenormImp=50ohm}} Impedance=50ohm
  2: Lumped Port Objects=Circle1_1 LumpedPortType=Modal Modes{Mode1{IntLine{(-1, 0.9, -0.49) -> (-1, 1, -0.49)} CharImp=Zpi RenormImp=50ohm}} Impedance=50ohm
  3: Lumped Port Objects=Circle1_2 LumpedPortType=Modal Modes{Mode1{IntLine{(6, 0.9, -0.49) -> (6, 1, -0.49)} CharImp=Zpi RenormImp=50ohm}} Impedance=50ohm
  4: Lumped Port Objects=Circle1_1_1 LumpedPortType=Modal Modes{Mode1{IntLine{(4, 0.9, -0.49) -> (4, 1, -0.49)} CharImp=Zpi RenormImp=50ohm}} Impedance=50ohm
  5: Lumped Port Objects=Circle1_3 LumpedPortType=Modal Modes{Mode1{IntLine{(11, 0.9, -0.49) -> (11, 1, -0.49)} CharImp=Zpi RenormImp=50ohm}} Impedance=50ohm
  6: Lumped Port Objects=Circle1_1_2 LumpedPortType=Modal Modes{Mode1{IntLine{(9, 0.9, -0.49) -> (9, 1, -0.49)} CharImp=Zpi RenormImp=50ohm}} Impedance=50ohm
  7: Lumped Port Objects=Circle1_4 LumpedPortType=Modal Modes{Mode1{IntLine{(16, 0.9, -0.49) -> (16, 1, -0.49)} CharImp=Zpi RenormImp=50ohm}} Impedance=50ohm
  8: Lumped Port Objects=Circle1_1_3 LumpedPortType=Modal Modes{Mode1{IntLine{(14, 0.9, -0.49) -> (14, 1, -0.49)} CharImp=Zpi RenormImp=50ohm}} Impedance=50ohm
setups:
  Setup1: HfssDriven Frequency=28GHz MaxDeltaS=0.02 MaximumPasses=1 MinimumPasses=1 MinimumConvergedPasses=1 PercentRefinement=30 BasisOrder=-1 PortAccuracy=2 DrivenSolverType="Direct Solver" VariableFlagsForDerivatives(1, 1, 1, 1, 1, 1)
    sweep Sweep: 26.5GHz to 29.5GHz step 1GHz; Type=Discrete SaveFields
source amplitudes:
  1:1: if(UseBeamPair,mag(pwl(ds_1_mag,beamID)*exp(cmplx(0,pwl(ds_1_phase,beamID)*pi/180))+pwl(ds_1_mag_bp,beamID)*exp(cmplx(0,BeamPair_PhaseOffset*pi/180deg+pwl(ds_1_phase_bp,beamID)*pi/180))),pwl(ds_1_mag,beamID)) 180deg/pi*if(UseBeamPair,ang_deg(pwl(ds_1_mag,beamID)*exp(cmplx(0,pwl(ds_1_phase,beamID)*pi/180))+pwl(ds_1_mag_bp,beamID)*exp(cmplx(0,BeamPair_PhaseOffset*pi/180deg+pwl(ds_1_phase_bp,beamID)*pi/180))),pwl(ds_1_phase,beamID)*1deg)
  2:1: if(UseBeamPair,mag(pwl(ds_2_mag,beamID)*exp(cmplx(0,pwl(ds_2_phase,beamID)*pi/180))+pwl(ds_2_mag_bp,beamID)*exp(cmplx(0,BeamPair_PhaseOffset*pi/180deg+pwl(ds_2_phase_bp,beamID)*pi/180))),pwl(ds_2_mag,beamID)) 180deg/pi*if(UseBeamPair,ang_deg(pwl(ds_2_mag,beamID)*exp(cmplx(0,pwl(ds_2_phase,beamID)*pi/180))+pwl(ds_2_mag_bp,beamID)*exp(cmplx(0,BeamPair_PhaseOffset*pi/180deg+pwl(ds_2_phase_bp,beamID)*pi/180))),pwl(ds_2_phase,beamID)*1deg)
  3:1: if(UseBeamPair,mag(pwl(ds_3_mag,beamID)*exp(cmplx(0,pwl(ds_3_phase,beamID)*pi/180))+pwl(ds_3_mag_bp,beamID)*exp(cmplx(0,BeamPair_PhaseOffset*pi/180deg+pwl(ds_3_phase_bp,beamID)*pi/180))),pwl(ds_3_mag,beamID)) 180deg/pi*if(UseBeamPair,ang_deg(pwl(ds_3_mag,beamID)*exp(cmplx(0,pwl(ds_3_phase,beamID)*pi/180))+pwl(ds_3_mag_bp,beamID)*exp(cmplx(0,BeamPair_PhaseOffset*pi/180deg+pwl(ds_3_phase_bp,beamID)*pi/180))),pwl(ds_3_phase,beamID)*1deg)
  4:1: if(UseBeamPair,mag(pwl(ds_4_mag,beamID)*exp(cmplx(0,pwl(ds_4_phase,beamID)*pi/180))+pwl(ds_4_mag_bp,beamID)*exp(cmplx(0,BeamPair_PhaseOffset*pi/180deg+pwl(ds_4_phase_bp,beamID)*pi/180))),pwl(ds_4_mag,beamID)) 180deg/pi*if(UseBeamPair,ang_deg(pwl(ds_4_mag,beamID)*exp(cmplx(0,pwl(ds_4_phase,beamID)*pi/180))+pwl(ds_4_mag_bp,beamID)*exp(cmplx(0,BeamPair_PhaseOffset*pi/180deg+pwl(ds_4_phase_bp,beamID)*pi/180))),pwl(ds_4_phase,beamID)*1deg)
  5:1: if(UseBeamPair,mag(pwl(ds_5_mag,beamID)*exp(cmplx(0,pwl(ds_5_phase,beamID)*pi/180))+pwl(ds_5_mag_bp,beamID)*exp(cmplx(0,BeamPair_PhaseOffset*pi/180deg+pwl(ds_5_phase_bp,beamID)*pi/180))),pwl(ds_5_mag,beamID)) 180deg/pi*if(UseBeamPair,ang_deg(pwl(ds_5_mag,beamID)*exp(cmplx(0,pwl(ds_5_phase,beamID)*pi/180))+pwl(ds_5_mag_bp,beamID)*exp(cmplx(0,BeamPair_PhaseOffset*pi/180deg+pwl(ds_5_phase_bp,beamID)*pi/180))),pwl(ds_5_phase,beamID)*1deg)
  6:1: if(UseBeamPair,mag(pwl(ds_6_mag,beamID)*exp(cmplx(0,pwl(ds_6_phase,beamID)*pi/180))+pwl(ds_6_mag_bp,beamID)*exp(cmplx(0,BeamPair_PhaseOffset*pi/180deg+pwl(ds_6_phase_bp,beamID)*pi/180))),pwl(ds_6_mag,beamID)) 180deg/pi*if(UseBeamPair,ang_deg(pwl(ds_6_mag,beamID)*exp(cmplx(0,pwl(ds_6_phase,beamID)*pi/180))+pwl(ds_6_mag_bp,beamID)*exp(cmplx(0,BeamPair_PhaseOffset*pi/180deg+pwl(ds_6_phase_bp,beamID)*pi/180))),pwl(ds_6_phase,beamID)*1deg)
  7:1: if(UseBeamPair,mag(pwl(ds_7_mag,beamID)*exp(cmplx(0,pwl(ds_7_phase,beamID)*pi/180))+pwl(ds_7_mag_bp,beamID)*exp(cmplx(0,BeamPair_PhaseOffset*pi/180deg+pwl(ds_7_phase_bp,beamID)*pi/180))),pwl(ds_7_mag,beamID)) 180deg/pi*if(UseBeamPair,ang_deg(pwl(ds_7_mag,beamID)*exp(cmplx(0,pwl(ds_7_phase,beamID)*pi/180))+pwl(ds_7_mag_bp,beamID)*exp(cmplx(0,BeamPair_PhaseOffset*pi/180deg+pwl(ds_7_phase_bp,beamID)*pi/180))),pwl(ds_7_phase,beamID)*1deg)
  8:1: if(UseBeamPair,mag(pwl(ds_8_mag,beamID)*exp(cmplx(0,pwl(ds_8_phase,beamID)*pi/180))+pwl(ds_8_mag_bp,beamID)*exp(cmplx(0,BeamPair_PhaseOffset*pi/180deg+pwl(ds_8_phase_bp,beamID)*pi/180))),pwl(ds_8_mag,beamID)) 180deg/pi*if(UseBeamPair,ang_deg(pwl(ds_8_mag,beamID)*exp(cmplx(0,pwl(ds_8_phase,beamID)*pi/180))+pwl(ds_8_mag_bp,beamID)*exp(cmplx(0,BeamPair_PhaseOffset*pi/180deg+pwl(ds_8_phase_bp,beamID)*pi/180))),pwl(ds_8_phase,beamID)*1deg)
radiation setups:
  3D: Infinite Sphere Theta=0deg..180deg step 2deg Phi=0deg..360deg step 2deg
  Elevation: Infinite Sphere Theta=-180deg..180deg step 1deg Phi=0deg..90deg step 90deg
  Azimuth: Infinite Sphere Theta=90deg..90deg step 0deg Phi=-180deg..180deg step 1deg
  RadSetup_FF_for_PD: Infinite Sphere Theta=0deg..180deg step 5deg Phi=-180deg..180deg step 5deg
  RadSetup_FF: Infinite Sphere Theta=0deg..180deg step 5deg Phi=-180deg..180deg step 5deg
  nf_setup_name: Near Rectangle  Length=0.045 Width=0.06 LengthSamples=46 WidthSamples=61 CoordSystem=nearfield_cs
output variables:
  Prad = 10*log10(AcceptedPower/1e-3)
field calculator expressions:
  Pz = Fundamental_Quantity(0) | <Hx,Hy,Hz> | Conj | Cross | 0.5 | * | ScalarZ | Real
reports:
  System Gain Plot 1: max(dB(SystemGainTotal)) vs Freq on Setup1 : LastAdaptive, RadSetup_FF [beamID=all Theta=all Phi=all]
  Realized Gain Plot 1: max(dB(RealizedGainTotal)) vs Freq on Setup1 : LastAdaptive, RadSetup_FF [beamID=all Theta=all Phi=all]; markers MX1 at x=-12.02621, MX2 at x=0.010752688
  Realized Gain Plot 2: max(RealizedGainTotal) vs Freq on Setup1 : LastAdaptive, RadSetup_FF [beamID=all Theta=all Phi=all]

design 4x1_array4 (HFSS, HFSS Modal Network, model units mm)
options: Allow_Material_Override Save_Adaptive_support_files
variables:
  # Antenna
  patchW = 3.23mm
  patchL = 3.23mm
  patch2L = 2.86mm
  patch2W = 2.86mm
  top_patch_offset = 0.6mm
  subW = 5mm
  subL = 5mm
  bot_patch_offset = 0.49mm
  # Feed
  feed_Xpos = 1mm
  feed_Ypos = 1mm
  cond_T = 0.008mm
  feed_via_rad = 0.05mm
  feed_subH = 0.27mm
  antipad_rad = 0.15mm
  # Setup
  beamID = 0  # beam ID for controlling array
  p1_mag = 1W
  p2_mag = 2W
  post_beamID = 0
  post_BeamPair_PhaseOffset = 0deg
  post_UseBeamPair = true
  BeamPair_PhaseOffset = 0deg  # phase offset to apply to beam pair
  UseBeamPair = true  # boolearn to select if beam pair is used
datasets:
  ds_5_mag: (0, 1) (1, 1) (2, 1) (3, 1) (4, 1)
  ds_5_phase: (0, 0) (1, 40) (2, 80) (3, -40) (4, -80)
  ds_4_mag: (0, 0) (1, 0) (2, 0) (3, 0) (4, 0)
  ds_4_phase: (0, 0) (1, 0) (2, 0) (3, 0) (4, 0)
  ds_7_mag: (0, 1) (1, 1) (2, 1) (3, 1) (4, 1)
  ds_7_phase: (0, 0) (1, 60) (2, 120) (3, -60) (4, -120)
  ds_6_mag: (0, 0) (1, 0) (2, 0) (3, 0) (4, 0)
  ds_6_phase: (0, 0) (1, 0) (2, 0) (3, 0) (4, 0)
  ds_1_mag: (0, 1) (1, 1) (2, 1) (3, 1) (4, 1)
  ds_1_phase: (0, 0) (1, 0) (2, 0) (3, 0) (4, 0)
  ds_3_mag: (0, 1) (1, 1) (2, 1) (3, 1) (4, 1)
  ds_3_phase: (0, 0) (1, 20) (2, 40) (3, -20) (4, -40)
  ds_2_mag: (0, 0) (1, 0) (2, 0) (3, 0) (4, 0)
  ds_2_phase: (0, 0) (1, 0) (2, 0) (3, 0) (4, 0)
  ds_8_mag: (0, 0) (1, 0) (2, 0) (3, 0) (4, 0)
  ds_8_phase: (0, 0) (1, 0) (2, 0) (3, 0) (4, 0)
  ds_1_mag1: (0, 1) (1, 1) (2, 1) (3, 1) (4, 1) (5, 0)
  ds_1_phase1: (0, 0) (1, 0) (2, 0) (3, 0) (4, 0) (5, 0)
  ds_1_mag_bp: (0, 0) (1, 0) (2, 0) (3, 0) (4, 0)
  ds_1_phase_bp: (0, 0) (1, 0) (2, 0) (3, 0) (4, 0)
  ds_2_mag1: (0, 0) (1, 0) (2, 0) (3, 0) (4, 0) (5, 1)
  ds_2_phase1: (0, 0) (1, 0) (2, 0) (3, 0) (4, 0) (5, 0)
  ds_2_mag_bp: (0, 0) (1, 0) (2, 0) (3, 0) (4, 0)
  ds_2_phase_bp: (0, 0) (1, 0) (2, 0) (3, 0) (4, 0)
  ds_3_mag1: (0, 1) (1, 1) (2, 1) (3, 1) (4, 1) (5, 0)
  ds_3_phase1: (0, 0) (1, 20) (2, 40) (3, -40) (4, -20) (5, 0)
  ds_3_mag_bp: (0, 0) (1, 0) (2, 0) (3, 0) (4, 0)
  ds_3_phase_bp: (0, 0) (1, 0) (2, 0) (3, 0) (4, 0)
  ds_4_mag1: (0, 0) (1, 0) (2, 0) (3, 0) (4, 0) (5, 1)
  ds_4_phase1: (0, 0) (1, 0) (2, 0) (3, 0) (4, 0) (5, 0)
  ds_4_mag_bp: (0, 0) (1, 0) (2, 0) (3, 0) (4, 0)
  ds_4_phase_bp: (0, 0) (1, 0) (2, 0) (3, 0) (4, 0)
  ds_5_mag1: (0, 1) (1, 1) (2, 1) (3, 1) (4, 1) (5, 0)
  ds_5_phase1: (0, 0) (1, 40) (2, 80) (3, -80) (4, -40) (5, 0)
  ds_5_mag_bp: (0, 0) (1, 0) (2, 0) (3, 0) (4, 0)
  ds_5_phase_bp: (0, 0) (1, 0) (2, 0) (3, 0) (4, 0)
  ds_6_mag1: (0, 0) (1, 0) (2, 0) (3, 0) (4, 0) (5, 1)
  ds_6_phase1: (0, 0) (1, 0) (2, 0) (3, 0) (4, 0) (5, 0)
  ds_6_mag_bp: (0, 0) (1, 0) (2, 0) (3, 0) (4, 0)
  ds_6_phase_bp: (0, 0) (1, 0) (2, 0) (3, 0) (4, 0)
  ds_7_mag1: (0, 1) (1, 1) (2, 1) (3, 1) (4, 1) (5, 0)
  ds_7_phase1: (0, 0) (1, 60) (2, 120) (3, -120) (4, -60) (5, 0)
  ds_7_mag_bp: (0, 0) (1, 0) (2, 0) (3, 0) (4, 0)
  ds_7_phase_bp: (0, 0) (1, 0) (2, 0) (3, 0) (4, 0)
  ds_8_mag1: (0, 0) (1, 0) (2, 0) (3, 0) (4, 0) (5, 1)
  ds_8_phase1: (0, 0) (1, 0) (2, 0) (3, 0) (4, 0) (5, 0)
  ds_8_mag_bp: (0, 0) (1, 0) (2, 0) (3, 0) (4, 0)
  ds_8_phase_bp: (0, 0) (1, 0) (2, 0) (3, 0) (4, 0)
geometry:
  bot_patch [copper] = rectangle(corner=(-patchW/2, -patchL/2, 0mm), x_size=patchW, y_size=patchL)
  top_patch [copper] = rectangle(corner=(-patch2W/2, -patch2L/2, top_patch_offset), x_size=patch2W, y_size=patch2L)
  ant_sub [ant_substrate] = box(corner=(-subW/2, -subL/2, top_patch_offset), size=(subW, subL, -top_patch_offset-bot_patch_offset))
  [top_patch, bot_patch].rotate(axis=Z, angle=45deg)
  gnd_ant [copper] = object_from(ant_sub.face(2 of 6))
  [top_patch, bot_patch].thicken(cond_T)
  feed_via_top [copper] = cylinder(axis=Z, base_centre=(feed_Xpos, feed_Ypos+feed_via_rad, 0mm), radius=feed_via_rad, height=-bot_patch_offset)
  gnd_ant.thicken(cond_T)
  Cylinder2 = cylinder(axis=Z, base_centre=(feed_Xpos, feed_Ypos+feed_via_rad, -bot_patch_offset), radius=antipad_rad, height=-cond_T)
  feed_via_top2 [copper] = feed_via_top.duplicate_mirror(point=(0mm, 0mm, 0.008mm), normal=(-1mm, 0mm, 0mm))
  Cylinder2_1 = Cylinder2.duplicate_mirror(point=(0mm, 0mm, 0.008mm), normal=(-1mm, 0mm, 0mm))
  gnd_ant.subtract(Cylinder2, Cylinder2_1)
  bot_sub = box(corner=(-subW/2, -subL/2, -bot_patch_offset), size=(subW, subL, -feed_subH-cond_T))
  gnd_bot = object_from(gnd_ant.face(2 of 6))
  gnd_bot.thicken(cond_T)
  Circle1 = circle(normal=Z, centre=(feed_Xpos, feed_Ypos+feed_via_rad, -bot_patch_offset), radius=antipad_rad)
  Circle1_1 = Circle1.duplicate_mirror(point=(0mm, 0mm, 0mm), normal=(1mm, 0mm, 0mm))
  bot_patch_1, bot_patch_2, bot_patch_3 [copper] = bot_patch.duplicate_along_line(step=(5mm, 0mm, 0mm), total=4)
  top_patch_1, top_patch_2, top_patch_3 [copper] = top_patch.duplicate_along_line(step=(5mm, 0mm, 0mm), total=4)
  ant_sub_1, ant_sub_2, ant_sub_3 = ant_sub.duplicate_along_line(step=(5mm, 0mm, 0mm), total=4)
  gnd_ant_1, gnd_ant_2, gnd_ant_3 = gnd_ant.duplicate_along_line(step=(5mm, 0mm, 0mm), total=4)
  feed_via_top_1, feed_via_top_2, feed_via_top_3 [copper] = feed_via_top.duplicate_along_line(step=(5mm, 0mm, 0mm), total=4)
  feed_via_top2_1, feed_via_top2_2, feed_via_top2_3 [copper] = feed_via_top2.duplicate_along_line(step=(5mm, 0mm, 0mm), total=4)
  bot_sub_1, bot_sub_2, bot_sub_3 = bot_sub.duplicate_along_line(step=(5mm, 0mm, 0mm), total=4)
  gnd_bot_1, gnd_bot_2, gnd_bot_3 = gnd_bot.duplicate_along_line(step=(5mm, 0mm, 0mm), total=4)
  Circle1_2, Circle1_3, Circle1_4 = Circle1.duplicate_along_line(step=(5mm, 0mm, 0mm), total=4)
  Circle1_1_1, Circle1_1_2, Circle1_1_3 = Circle1_1.duplicate_along_line(step=(5mm, 0mm, 0mm), total=4)
  RadiatingSurface [vacuum] = region(absolute_offset=3.5714286mm on all sides)
  ant_sub.unite(ant_sub_1, ant_sub_2, ant_sub_3)
  bot_sub.unite(bot_sub_1, bot_sub_2, bot_sub_3)
  gnd_ant.unite(gnd_ant_1, gnd_ant_2, gnd_ant_3)
  gnd_ant.unite(bot_sub)
  gnd_ant.unite(gnd_bot, gnd_bot_1, gnd_bot_2, gnd_bot_3)
  5mm_Surface [non-model] = rectangle(corner=(-2.5mm, -2.5mm, 0.6mm), x_size=20mm, y_size=5mm)
  5mm_Surface.move(0mm, 0mm, 5mm)
  5mm_Surface.move_edges(MoveAlongNormalFlag=true OffsetDistance=20mm EdgesToMove=5mm_Surface.edge(all 4))
  20mm_Surface [non-model] = rectangle(corner=(-2.5mm, -2.5mm, 0.6mm), x_size=20mm, y_size=5mm)
  20mm_Surface.move(0mm, 0mm, 20mm)
  20mm_Surface.move_edges(MoveAlongNormalFlag=true OffsetDistance=60mm EdgesToMove=20mm_Surface.edge(all 4))
  50mm_Surface [non-model] = rectangle(corner=(-2.5mm, -2.5mm, 0.6mm), x_size=20mm, y_size=5mm)
  50mm_Surface.move(0mm, 0mm, 50mm)
  50mm_Surface.move_edges(MoveAlongNormalFlag=true OffsetDistance=100mm EdgesToMove=50mm_Surface.edge(all 4))
  coordinate_system nearfield_cs = origin=(7.5mm, 3.9641673e-31mm, 20.6mm) x=(0mm, 0mm, -1mm) y=(-1mm, 0mm, 0mm)
  25mm_Surface [non-model] = rectangle(corner=(-2.5mm, -2.5mm, 0.6mm), x_size=20mm, y_size=5mm) in nearfield_cs
  25mm_Surface.move(0mm, 0mm, 25mm) in nearfield_cs
  25mm_Surface.move_edges(MoveAlongNormalFlag=true OffsetDistance=80mm EdgesToMove=25mm_Surface.edge(all 4)) in nearfield_cs
  [bot_patch, top_patch, ant_sub, gnd_ant, feed_via_top, feed_via_top2, Circle1, Circle1_1, bot_patch_1, bot_patch_2, bot_patch_3, top_patch_1, top_patch_2, top_patch_3, feed_via_top_1, feed_via_top_2, feed_via_top_3, feed_via_top2_1, feed_via_top2_2, feed_via_top2_3, Circle1_2, Circle1_3, Circle1_4, Circle1_1_1, Circle1_1_2, Circle1_1_3, 5mm_Surface, 20mm_Surface, 50mm_Surface, 25mm_Surface].rotate(axis=Y, angle=90deg) in nearfield_cs
boundaries and excitations:
  Open1: Radiation Objects=RadiatingSurface
  1: Lumped Port Objects=Circle1 LumpedPortType=Modal Modes{Mode1{IntLine{(1, -21.09, 19.7) -> (1, -21.09, 19.6)} CharImp=Zpi RenormImp=50ohm}} Impedance=50ohm
  2: Lumped Port Objects=Circle1_1 LumpedPortType=Modal Modes{Mode1{IntLine{(-1, -21.09, 19.7) -> (-1, -21.09, 19.6)} CharImp=Zpi RenormImp=50ohm}} Impedance=50ohm
  3: Lumped Port Objects=Circle1_2 LumpedPortType=Modal Modes{Mode1{IntLine{(6, -21.09, 19.7) -> (6, -21.09, 19.6)} CharImp=Zpi RenormImp=50ohm}} Impedance=50ohm
  4: Lumped Port Objects=Circle1_1_1 LumpedPortType=Modal Modes{Mode1{IntLine{(4, -21.09, 19.7) -> (4, -21.09, 19.6)} CharImp=Zpi RenormImp=50ohm}} Impedance=50ohm
  5: Lumped Port Objects=Circle1_3 LumpedPortType=Modal Modes{Mode1{IntLine{(11, -21.09, 19.7) -> (11, -21.09, 19.6)} CharImp=Zpi RenormImp=50ohm}} Impedance=50ohm
  6: Lumped Port Objects=Circle1_1_2 LumpedPortType=Modal Modes{Mode1{IntLine{(9, -21.09, 19.7) -> (9, -21.09, 19.6)} CharImp=Zpi RenormImp=50ohm}} Impedance=50ohm
  7: Lumped Port Objects=Circle1_4 LumpedPortType=Modal Modes{Mode1{IntLine{(16, -21.09, 19.7) -> (16, -21.09, 19.6)} CharImp=Zpi RenormImp=50ohm}} Impedance=50ohm
  8: Lumped Port Objects=Circle1_1_3 LumpedPortType=Modal Modes{Mode1{IntLine{(14, -21.09, 19.7) -> (14, -21.09, 19.6)} CharImp=Zpi RenormImp=50ohm}} Impedance=50ohm
setups:
  Setup1: HfssDriven Frequency=28GHz MaxDeltaS=0.02 MaximumPasses=1 MinimumPasses=1 MinimumConvergedPasses=1 PercentRefinement=30 BasisOrder=-1 PortAccuracy=2 DrivenSolverType="Direct Solver" VariableFlagsForDerivatives(1, 1, 1, 1, 1, 1)
    sweep Sweep: 26.5GHz to 29.5GHz step 1GHz; Type=Discrete SaveFields
source amplitudes:
  1:1: if(UseBeamPair,mag(pwl(ds_1_mag,beamID)*exp(cmplx(0,pwl(ds_1_phase,beamID)*pi/180))+pwl(ds_1_mag_bp,beamID)*exp(cmplx(0,BeamPair_PhaseOffset*pi/180deg+pwl(ds_1_phase_bp,beamID)*pi/180))),pwl(ds_1_mag,beamID)) 180deg/pi*if(UseBeamPair,ang_deg(pwl(ds_1_mag,beamID)*exp(cmplx(0,pwl(ds_1_phase,beamID)*pi/180))+pwl(ds_1_mag_bp,beamID)*exp(cmplx(0,BeamPair_PhaseOffset*pi/180deg+pwl(ds_1_phase_bp,beamID)*pi/180))),pwl(ds_1_phase,beamID)*1deg)
  2:1: if(UseBeamPair,mag(pwl(ds_2_mag,beamID)*exp(cmplx(0,pwl(ds_2_phase,beamID)*pi/180))+pwl(ds_2_mag_bp,beamID)*exp(cmplx(0,BeamPair_PhaseOffset*pi/180deg+pwl(ds_2_phase_bp,beamID)*pi/180))),pwl(ds_2_mag,beamID)) 180deg/pi*if(UseBeamPair,ang_deg(pwl(ds_2_mag,beamID)*exp(cmplx(0,pwl(ds_2_phase,beamID)*pi/180))+pwl(ds_2_mag_bp,beamID)*exp(cmplx(0,BeamPair_PhaseOffset*pi/180deg+pwl(ds_2_phase_bp,beamID)*pi/180))),pwl(ds_2_phase,beamID)*1deg)
  3:1: if(UseBeamPair,mag(pwl(ds_3_mag,beamID)*exp(cmplx(0,pwl(ds_3_phase,beamID)*pi/180))+pwl(ds_3_mag_bp,beamID)*exp(cmplx(0,BeamPair_PhaseOffset*pi/180deg+pwl(ds_3_phase_bp,beamID)*pi/180))),pwl(ds_3_mag,beamID)) 180deg/pi*if(UseBeamPair,ang_deg(pwl(ds_3_mag,beamID)*exp(cmplx(0,pwl(ds_3_phase,beamID)*pi/180))+pwl(ds_3_mag_bp,beamID)*exp(cmplx(0,BeamPair_PhaseOffset*pi/180deg+pwl(ds_3_phase_bp,beamID)*pi/180))),pwl(ds_3_phase,beamID)*1deg)
  4:1: if(UseBeamPair,mag(pwl(ds_4_mag,beamID)*exp(cmplx(0,pwl(ds_4_phase,beamID)*pi/180))+pwl(ds_4_mag_bp,beamID)*exp(cmplx(0,BeamPair_PhaseOffset*pi/180deg+pwl(ds_4_phase_bp,beamID)*pi/180))),pwl(ds_4_mag,beamID)) 180deg/pi*if(UseBeamPair,ang_deg(pwl(ds_4_mag,beamID)*exp(cmplx(0,pwl(ds_4_phase,beamID)*pi/180))+pwl(ds_4_mag_bp,beamID)*exp(cmplx(0,BeamPair_PhaseOffset*pi/180deg+pwl(ds_4_phase_bp,beamID)*pi/180))),pwl(ds_4_phase,beamID)*1deg)
  5:1: if(UseBeamPair,mag(pwl(ds_5_mag,beamID)*exp(cmplx(0,pwl(ds_5_phase,beamID)*pi/180))+pwl(ds_5_mag_bp,beamID)*exp(cmplx(0,BeamPair_PhaseOffset*pi/180deg+pwl(ds_5_phase_bp,beamID)*pi/180))),pwl(ds_5_mag,beamID)) 180deg/pi*if(UseBeamPair,ang_deg(pwl(ds_5_mag,beamID)*exp(cmplx(0,pwl(ds_5_phase,beamID)*pi/180))+pwl(ds_5_mag_bp,beamID)*exp(cmplx(0,BeamPair_PhaseOffset*pi/180deg+pwl(ds_5_phase_bp,beamID)*pi/180))),pwl(ds_5_phase,beamID)*1deg)
  6:1: if(UseBeamPair,mag(pwl(ds_6_mag,beamID)*exp(cmplx(0,pwl(ds_6_phase,beamID)*pi/180))+pwl(ds_6_mag_bp,beamID)*exp(cmplx(0,BeamPair_PhaseOffset*pi/180deg+pwl(ds_6_phase_bp,beamID)*pi/180))),pwl(ds_6_mag,beamID)) 180deg/pi*if(UseBeamPair,ang_deg(pwl(ds_6_mag,beamID)*exp(cmplx(0,pwl(ds_6_phase,beamID)*pi/180))+pwl(ds_6_mag_bp,beamID)*exp(cmplx(0,BeamPair_PhaseOffset*pi/180deg+pwl(ds_6_phase_bp,beamID)*pi/180))),pwl(ds_6_phase,beamID)*1deg)
  7:1: if(UseBeamPair,mag(pwl(ds_7_mag,beamID)*exp(cmplx(0,pwl(ds_7_phase,beamID)*pi/180))+pwl(ds_7_mag_bp,beamID)*exp(cmplx(0,BeamPair_PhaseOffset*pi/180deg+pwl(ds_7_phase_bp,beamID)*pi/180))),pwl(ds_7_mag,beamID)) 180deg/pi*if(UseBeamPair,ang_deg(pwl(ds_7_mag,beamID)*exp(cmplx(0,pwl(ds_7_phase,beamID)*pi/180))+pwl(ds_7_mag_bp,beamID)*exp(cmplx(0,BeamPair_PhaseOffset*pi/180deg+pwl(ds_7_phase_bp,beamID)*pi/180))),pwl(ds_7_phase,beamID)*1deg)
  8:1: if(UseBeamPair,mag(pwl(ds_8_mag,beamID)*exp(cmplx(0,pwl(ds_8_phase,beamID)*pi/180))+pwl(ds_8_mag_bp,beamID)*exp(cmplx(0,BeamPair_PhaseOffset*pi/180deg+pwl(ds_8_phase_bp,beamID)*pi/180))),pwl(ds_8_mag,beamID)) 180deg/pi*if(UseBeamPair,ang_deg(pwl(ds_8_mag,beamID)*exp(cmplx(0,pwl(ds_8_phase,beamID)*pi/180))+pwl(ds_8_mag_bp,beamID)*exp(cmplx(0,BeamPair_PhaseOffset*pi/180deg+pwl(ds_8_phase_bp,beamID)*pi/180))),pwl(ds_8_phase,beamID)*1deg)
radiation setups:
  3D: Infinite Sphere Theta=0deg..180deg step 2deg Phi=0deg..360deg step 2deg
  Elevation: Infinite Sphere Theta=-180deg..180deg step 1deg Phi=0deg..90deg step 90deg
  Azimuth: Infinite Sphere Theta=90deg..90deg step 0deg Phi=-180deg..180deg step 1deg
  RadSetup_FF_for_PD: Infinite Sphere Theta=0deg..180deg step 5deg Phi=-180deg..180deg step 5deg
  RadSetup_FF: Infinite Sphere Theta=0deg..180deg step 5deg Phi=-180deg..180deg step 5deg
  nf_setup_name: Near Rectangle  Length=0.125 Width=0.14 LengthSamples=126 WidthSamples=141 CoordSystem=nearfield_cs
output variables:
  Prad = 10*log10(AcceptedPower/1e-3)
field calculator expressions:
  Pz = Fundamental_Quantity(0) | <Hx,Hy,Hz> | Conj | Cross | 0.5 | * | ScalarZ | Real
reports:
  Realized Gain Plot 1: dB(RealizedGainTotal) vs Theta, Phi on Setup1 : LastAdaptive, RadSetup_FF [Freq=28GHz]

design 4x1_array5 (HFSS, HFSS Modal Network, model units mm)
options: Allow_Material_Override Save_Adaptive_support_files
variables:
  # Antenna
  patchW = 3.23mm
  patchL = 3.23mm
  patch2L = 2.86mm
  patch2W = 2.86mm
  top_patch_offset = 0.6mm
  subW = 5mm
  subL = 5mm
  bot_patch_offset = 0.49mm
  # Feed
  feed_Xpos = 1mm
  feed_Ypos = 1mm
  cond_T = 0.008mm
  feed_via_rad = 0.05mm
  feed_subH = 0.27mm
  antipad_rad = 0.15mm
  # Setup
  post_beamID = 0
  beamID = 5  # beam ID for controlling array
  BeamPair_PhaseOffset = 0deg  # phase offset to apply to beam pair
  UseBeamPair = true  # boolearn to select if beam pair is used
datasets:
  ds_5_mag: (0, 1) (1, 1) (2, 1) (3, 1) (4, 1) (5, 0) (6, 0) (7, 0) (8, 0) (9, 0)
  ds_5_phase: (0, 0) (1, 40) (2, 80) (3, -40) (4, -80) (5, 0) (6, 0) (7, 0) (8, 0) (9, 0)
  ds_4_mag: (0, 0) (1, 0) (2, 0) (3, 0) (4, 0) (5, 1) (6, 1) (7, 1) (8, 1) (9, 1)
  ds_4_phase: (0, 0) (1, 0) (2, 0) (3, 0) (4, 0) (5, 0) (6, 20) (7, 40) (8, -20) (9, -40)
  ds_7_mag: (0, 1) (1, 1) (2, 1) (3, 1) (4, 1) (5, 0) (6, 0) (7, 0) (8, 0) (9, 0)
  ds_7_phase: (0, 0) (1, 60) (2, 120) (3, -60) (4, -120) (5, 0) (6, 0) (7, 0) (8, 0) (9, 0)
  ds_6_mag: (0, 0) (1, 0) (2, 0) (3, 0) (4, 0) (5, 1) (6, 1) (7, 1) (8, 1) (9, 1)
  ds_6_phase: (0, 0) (1, 0) (2, 0) (3, 0) (4, 0) (5, 0) (6, 40) (7, 80) (8, -40) (9, -80)
  ds_1_mag: (0, 1) (1, 1) (2, 1) (3, 1) (4, 1) (5, 0) (6, 0) (7, 0) (8, 0) (9, 0)
  ds_1_phase: (0, 0) (1, 0) (2, 0) (3, 0) (4, 0) (5, 0) (6, 0) (7, 0) (8, 0) (9, 0)
  ds_3_mag: (0, 1) (1, 1) (2, 1) (3, 1) (4, 1) (5, 0) (6, 0) (7, 0) (8, 0) (9, 0)
  ds_3_phase: (0, 0) (1, 20) (2, 40) (3, -20) (4, -40) (5, 0) (6, 0) (7, 0) (8, 0) (9, 0)
  ds_2_mag: (0, 0) (1, 0) (2, 0) (3, 0) (4, 0) (5, 1) (6, 1) (7, 1) (8, 1) (9, 1)
  ds_2_phase: (0, 0) (1, 0) (2, 0) (3, 0) (4, 0) (5, 0) (6, 0) (7, 0) (8, 0) (9, 0)
  ds_8_mag: (0, 0) (1, 0) (2, 0) (3, 0) (4, 0) (5, 1) (6, 1) (7, 1) (8, 1) (9, 1)
  ds_8_phase: (0, 0) (1, 0) (2, 0) (3, 0) (4, 0) (5, 0) (6, 60) (7, 120) (8, -60) (9, -120)
  ds_1_mag1: (0, 1) (1, 1) (2, 1) (3, 1) (4, 1) (5, 0)
  ds_1_phase1: (0, 0) (1, 0) (2, 0) (3, 0) (4, 0) (5, 0)
  ds_1_mag_bp: (0, 0) (1, 0) (2, 0) (3, 0) (4, 0) (5, 1) (6, 1) (7, 1) (8, 1) (9, 1)
  ds_1_phase_bp: (0, 0) (1, 0) (2, 0) (3, 0) (4, 0) (5, 0) (6, 0) (7, 0) (8, 0) (9, 0)
  ds_2_mag1: (0, 0) (1, 0) (2, 0) (3, 0) (4, 0) (5, 1)
  ds_2_phase1: (0, 0) (1, 0) (2, 0) (3, 0) (4, 0) (5, 0)
  ds_2_mag_bp: (0, 1) (1, 1) (2, 1) (3, 1) (4, 1) (5, 0) (6, 0) (7, 0) (8, 0) (9, 0)
  ds_2_phase_bp: (0, 0) (1, 0) (2, 0) (3, 0) (4, 0) (5, 0) (6, 0) (7, 0) (8, 0) (9, 0)
  ds_3_mag1: (0, 1) (1, 1) (2, 1) (3, 1) (4, 1) (5, 0)
  ds_3_phase1: (0, 0) (1, 20) (2, 40) (3, -40) (4, -20) (5, 0)
  ds_3_mag_bp: (0, 0) (1, 0) (2, 0) (3, 0) (4, 0) (5, 1) (6, 1) (7, 1) (8, 1) (9, 1)
  ds_3_phase_bp: (0, 0) (1, 0) (2, 0) (3, 0) (4, 0) (5, 0) (6, 20) (7, 40) (8, -20) (9, -40)
  ds_4_mag1: (0, 0) (1, 0) (2, 0) (3, 0) (4, 0) (5, 1)
  ds_4_phase1: (0, 0) (1, 0) (2, 0) (3, 0) (4, 0) (5, 0)
  ds_4_mag_bp: (0, 1) (1, 1) (2, 1) (3, 1) (4, 1) (5, 0) (6, 0) (7, 0) (8, 0) (9, 0)
  ds_4_phase_bp: (0, 0) (1, 20) (2, 40) (3, -20) (4, -40) (5, 0) (6, 0) (7, 0) (8, 0) (9, 0)
  ds_5_mag1: (0, 1) (1, 1) (2, 1) (3, 1) (4, 1) (5, 0)
  ds_5_phase1: (0, 0) (1, 40) (2, 80) (3, -80) (4, -40) (5, 0)
  ds_5_mag_bp: (0, 0) (1, 0) (2, 0) (3, 0) (4, 0) (5, 1) (6, 1) (7, 1) (8, 1) (9, 1)
  ds_5_phase_bp: (0, 0) (1, 0) (2, 0) (3, 0) (4, 0) (5, 0) (6, 40) (7, 80) (8, -40) (9, -80)
  ds_6_mag1: (0, 0) (1, 0) (2, 0) (3, 0) (4, 0) (5, 1)
  ds_6_phase1: (0, 0) (1, 0) (2, 0) (3, 0) (4, 0) (5, 0)
  ds_6_mag_bp: (0, 1) (1, 1) (2, 1) (3, 1) (4, 1) (5, 0) (6, 0) (7, 0) (8, 0) (9, 0)
  ds_6_phase_bp: (0, 0) (1, 40) (2, 80) (3, -40) (4, -80) (5, 0) (6, 0) (7, 0) (8, 0) (9, 0)
  ds_7_mag1: (0, 1) (1, 1) (2, 1) (3, 1) (4, 1) (5, 0)
  ds_7_phase1: (0, 0) (1, 60) (2, 120) (3, -120) (4, -60) (5, 0)
  ds_7_mag_bp: (0, 0) (1, 0) (2, 0) (3, 0) (4, 0) (5, 1) (6, 1) (7, 1) (8, 1) (9, 1)
  ds_7_phase_bp: (0, 0) (1, 0) (2, 0) (3, 0) (4, 0) (5, 0) (6, 60) (7, 120) (8, -60) (9, -120)
  ds_8_mag1: (0, 0) (1, 0) (2, 0) (3, 0) (4, 0) (5, 1)
  ds_8_phase1: (0, 0) (1, 0) (2, 0) (3, 0) (4, 0) (5, 0)
  ds_8_mag_bp: (0, 1) (1, 1) (2, 1) (3, 1) (4, 1) (5, 0) (6, 0) (7, 0) (8, 0) (9, 0)
  ds_8_phase_bp: (0, 0) (1, 60) (2, 120) (3, -60) (4, -120) (5, 0) (6, 0) (7, 0) (8, 0) (9, 0)
geometry:
  bot_patch [copper] = rectangle(corner=(-patchW/2, -patchL/2, 0mm), x_size=patchW, y_size=patchL)
  top_patch [copper] = rectangle(corner=(-patch2W/2, -patch2L/2, top_patch_offset), x_size=patch2W, y_size=patch2L)
  ant_sub [ant_substrate] = box(corner=(-subW/2, -subL/2, top_patch_offset), size=(subW, subL, -top_patch_offset-bot_patch_offset))
  [top_patch, bot_patch].rotate(axis=Z, angle=45deg)
  gnd_ant [copper] = object_from(ant_sub.face(-z))
  [top_patch, bot_patch].thicken(cond_T)
  feed_via_top [copper] = cylinder(axis=Z, base_centre=(feed_Xpos, feed_Ypos+feed_via_rad, 0mm), radius=feed_via_rad, height=-bot_patch_offset)
  gnd_ant.thicken(cond_T)
  Cylinder2 = cylinder(axis=Z, base_centre=(feed_Xpos, feed_Ypos+feed_via_rad, -bot_patch_offset), radius=antipad_rad, height=-cond_T)
  feed_via_top2 [copper] = feed_via_top.duplicate_mirror(point=(0mm, 0mm, 0.008mm), normal=(-1mm, 0mm, 0mm))
  Cylinder2_1 = Cylinder2.duplicate_mirror(point=(0mm, 0mm, 0.008mm), normal=(-1mm, 0mm, 0mm))
  gnd_ant.subtract(Cylinder2, Cylinder2_1)
  bot_sub = box(corner=(-subW/2, -subL/2, -bot_patch_offset), size=(subW, subL, -feed_subH-cond_T))
  gnd_bot = object_from(gnd_ant.face(2 of 6))
  gnd_bot.thicken(cond_T)
  Circle1 = circle(normal=Z, centre=(feed_Xpos, feed_Ypos+feed_via_rad, -bot_patch_offset), radius=antipad_rad)
  Circle1_1 = Circle1.duplicate_mirror(point=(0mm, 0mm, 0mm), normal=(1mm, 0mm, 0mm))
  bot_patch_1, bot_patch_2, bot_patch_3 [copper] = bot_patch.duplicate_along_line(step=(5mm, 0mm, 0mm), total=4)
  top_patch_1, top_patch_2, top_patch_3 [copper] = top_patch.duplicate_along_line(step=(5mm, 0mm, 0mm), total=4)
  ant_sub_1, ant_sub_2, ant_sub_3 = ant_sub.duplicate_along_line(step=(5mm, 0mm, 0mm), total=4)
  gnd_ant_1, gnd_ant_2, gnd_ant_3 = gnd_ant.duplicate_along_line(step=(5mm, 0mm, 0mm), total=4)
  feed_via_top_1, feed_via_top_2, feed_via_top_3 [copper] = feed_via_top.duplicate_along_line(step=(5mm, 0mm, 0mm), total=4)
  feed_via_top2_1, feed_via_top2_2, feed_via_top2_3 [copper] = feed_via_top2.duplicate_along_line(step=(5mm, 0mm, 0mm), total=4)
  bot_sub_1, bot_sub_2, bot_sub_3 = bot_sub.duplicate_along_line(step=(5mm, 0mm, 0mm), total=4)
  gnd_bot_1, gnd_bot_2, gnd_bot_3 = gnd_bot.duplicate_along_line(step=(5mm, 0mm, 0mm), total=4)
  Circle1_2, Circle1_3, Circle1_4 = Circle1.duplicate_along_line(step=(5mm, 0mm, 0mm), total=4)
  Circle1_1_1, Circle1_1_2, Circle1_1_3 = Circle1_1.duplicate_along_line(step=(5mm, 0mm, 0mm), total=4)
  RadiatingSurface [vacuum] = region(absolute_offset=3.5714286mm on all sides)
  ant_sub.unite(ant_sub_1, ant_sub_2, ant_sub_3)
  bot_sub.unite(bot_sub_1, bot_sub_2, bot_sub_3)
  gnd_ant.unite(gnd_ant_1, gnd_ant_2, gnd_ant_3)
  gnd_ant.unite(bot_sub)
  gnd_ant.unite(gnd_bot, gnd_bot_1, gnd_bot_2, gnd_bot_3)
  5mm_Surface [non-model] = rectangle(corner=(-2.5mm, -2.5mm, 0.6mm), x_size=20mm, y_size=5mm)
  5mm_Surface.move(0mm, 0mm, 5mm)
  5mm_Surface.move_edges(MoveAlongNormalFlag=true OffsetDistance=20mm EdgesToMove=5mm_Surface.edge(all 4))
  20mm_Surface [non-model] = rectangle(corner=(-2.5mm, -2.5mm, 0.6mm), x_size=20mm, y_size=5mm)
  20mm_Surface.move(0mm, 0mm, 20mm)
  20mm_Surface.move_edges(MoveAlongNormalFlag=true OffsetDistance=60mm EdgesToMove=20mm_Surface.edge(all 4))
  50mm_Surface [non-model] = rectangle(corner=(-2.5mm, -2.5mm, 0.6mm), x_size=20mm, y_size=5mm)
  50mm_Surface.move(0mm, 0mm, 50mm)
  50mm_Surface.move_edges(MoveAlongNormalFlag=true OffsetDistance=100mm EdgesToMove=50mm_Surface.edge(all 4))
  coordinate_system RelativeCS1 = origin=(1mm, 1.05mm, -0.49mm) x=(1mm, 0mm, 0mm) y=(0mm, 1mm, 0mm)
  coordinate_system RelativeCS2 = origin=(-2mm, 0mm, 0mm) x=(1mm, 0mm, 0mm) y=(0mm, 1mm, 0mm) in RelativeCS1
  coordinate_system RelativeCS3 = origin=(6mm, 1.05mm, -0.49mm) x=(1mm, 0mm, 0mm) y=(0mm, 1mm, 0mm)
  coordinate_system RelativeCS4 = origin=(-2mm, 0mm, 0mm) x=(1mm, 0mm, 0mm) y=(0mm, 1mm, 0mm) in RelativeCS3
  coordinate_system RelativeCS5 = origin=(7mm, 0mm, 0mm) x=(1mm, 0mm, 0mm) y=(0mm, 1mm, 0mm) in RelativeCS4
  coordinate_system RelativeCS6 = origin=(-2mm, 0mm, 0mm) x=(1mm, 0mm, 0mm) y=(0mm, 1mm, 0mm) in RelativeCS5
  coordinate_system RelativeCS7 = origin=(7mm, 0mm, 0mm) x=(1mm, 0mm, 0mm) y=(0mm, 1mm, 0mm) in RelativeCS6
  coordinate_system RelativeCS8 = origin=(-2mm, 0mm, 0mm) x=(1mm, 0mm, 0mm) y=(0mm, 1mm, 0mm) in RelativeCS7
boundaries and excitations:
  Open1: Radiation Objects=RadiatingSurface
  1: Lumped Port Objects=Circle1 LumpedPortType=Modal Modes{Mode1{IntLine{(1, 0.9, -0.49) -> (1, 1, -0.49)} CharImp=Zpi RenormImp=50ohm}} Impedance=50ohm
  2: Lumped Port Objects=Circle1_1 LumpedPortType=Modal Modes{Mode1{IntLine{(-1, 0.9, -0.49) -> (-1, 1, -0.49)} CharImp=Zpi RenormImp=50ohm}} Impedance=50ohm
  3: Lumped Port Objects=Circle1_2 LumpedPortType=Modal Modes{Mode1{IntLine{(6, 0.9, -0.49) -> (6, 1, -0.49)} CharImp=Zpi RenormImp=50ohm}} Impedance=50ohm
  4: Lumped Port Objects=Circle1_1_1 LumpedPortType=Modal Modes{Mode1{IntLine{(4, 0.9, -0.49) -> (4, 1, -0.49)} CharImp=Zpi RenormImp=50ohm}} Impedance=50ohm
  5: Lumped Port Objects=Circle1_3 LumpedPortType=Modal Modes{Mode1{IntLine{(11, 0.9, -0.49) -> (11, 1, -0.49)} CharImp=Zpi RenormImp=50ohm}} Impedance=50ohm
  6: Lumped Port Objects=Circle1_1_2 LumpedPortType=Modal Modes{Mode1{IntLine{(9, 0.9, -0.49) -> (9, 1, -0.49)} CharImp=Zpi RenormImp=50ohm}} Impedance=50ohm
  7: Lumped Port Objects=Circle1_4 LumpedPortType=Modal Modes{Mode1{IntLine{(16, 0.9, -0.49) -> (16, 1, -0.49)} CharImp=Zpi RenormImp=50ohm}} Impedance=50ohm
  8: Lumped Port Objects=Circle1_1_3 LumpedPortType=Modal Modes{Mode1{IntLine{(14, 0.9, -0.49) -> (14, 1, -0.49)} CharImp=Zpi RenormImp=50ohm}} Impedance=50ohm
setups:
  Setup1: HfssDriven Frequency=28GHz MaxDeltaS=0.02 MaximumPasses=20 MinimumPasses=1 MinimumConvergedPasses=1 PercentRefinement=30 BasisOrder=-1 PortAccuracy=2 DrivenSolverType="Direct Solver" VariableFlagsForDerivatives(1, 1, 1, 1, 1, 1)
source amplitudes:
  1:1: if(UseBeamPair,mag(pwl(ds_1_mag,beamID)*exp(cmplx(0,pwl(ds_1_phase,beamID)*pi/180))+pwl(ds_1_mag_bp,beamID)*exp(cmplx(0,BeamPair_PhaseOffset*pi/180deg+pwl(ds_1_phase_bp,beamID)*pi/180))),pwl(ds_1_mag,beamID)) 180deg/pi*if(UseBeamPair,ang_deg(pwl(ds_1_mag,beamID)*exp(cmplx(0,pwl(ds_1_phase,beamID)*pi/180))+pwl(ds_1_mag_bp,beamID)*exp(cmplx(0,BeamPair_PhaseOffset*pi/180deg+pwl(ds_1_phase_bp,beamID)*pi/180))),pwl(ds_1_phase,beamID)*1deg)
  2:1: if(UseBeamPair,mag(pwl(ds_2_mag,beamID)*exp(cmplx(0,pwl(ds_2_phase,beamID)*pi/180))+pwl(ds_2_mag_bp,beamID)*exp(cmplx(0,BeamPair_PhaseOffset*pi/180deg+pwl(ds_2_phase_bp,beamID)*pi/180))),pwl(ds_2_mag,beamID)) 180deg/pi*if(UseBeamPair,ang_deg(pwl(ds_2_mag,beamID)*exp(cmplx(0,pwl(ds_2_phase,beamID)*pi/180))+pwl(ds_2_mag_bp,beamID)*exp(cmplx(0,BeamPair_PhaseOffset*pi/180deg+pwl(ds_2_phase_bp,beamID)*pi/180))),pwl(ds_2_phase,beamID)*1deg)
  3:1: if(UseBeamPair,mag(pwl(ds_3_mag,beamID)*exp(cmplx(0,pwl(ds_3_phase,beamID)*pi/180))+pwl(ds_3_mag_bp,beamID)*exp(cmplx(0,BeamPair_PhaseOffset*pi/180deg+pwl(ds_3_phase_bp,beamID)*pi/180))),pwl(ds_3_mag,beamID)) 180deg/pi*if(UseBeamPair,ang_deg(pwl(ds_3_mag,beamID)*exp(cmplx(0,pwl(ds_3_phase,beamID)*pi/180))+pwl(ds_3_mag_bp,beamID)*exp(cmplx(0,BeamPair_PhaseOffset*pi/180deg+pwl(ds_3_phase_bp,beamID)*pi/180))),pwl(ds_3_phase,beamID)*1deg)
  4:1: if(UseBeamPair,mag(pwl(ds_4_mag,beamID)*exp(cmplx(0,pwl(ds_4_phase,beamID)*pi/180))+pwl(ds_4_mag_bp,beamID)*exp(cmplx(0,BeamPair_PhaseOffset*pi/180deg+pwl(ds_4_phase_bp,beamID)*pi/180))),pwl(ds_4_mag,beamID)) 180deg/pi*if(UseBeamPair,ang_deg(pwl(ds_4_mag,beamID)*exp(cmplx(0,pwl(ds_4_phase,beamID)*pi/180))+pwl(ds_4_mag_bp,beamID)*exp(cmplx(0,BeamPair_PhaseOffset*pi/180deg+pwl(ds_4_phase_bp,beamID)*pi/180))),pwl(ds_4_phase,beamID)*1deg)
  5:1: if(UseBeamPair,mag(pwl(ds_5_mag,beamID)*exp(cmplx(0,pwl(ds_5_phase,beamID)*pi/180))+pwl(ds_5_mag_bp,beamID)*exp(cmplx(0,BeamPair_PhaseOffset*pi/180deg+pwl(ds_5_phase_bp,beamID)*pi/180))),pwl(ds_5_mag,beamID)) 180deg/pi*if(UseBeamPair,ang_deg(pwl(ds_5_mag,beamID)*exp(cmplx(0,pwl(ds_5_phase,beamID)*pi/180))+pwl(ds_5_mag_bp,beamID)*exp(cmplx(0,BeamPair_PhaseOffset*pi/180deg+pwl(ds_5_phase_bp,beamID)*pi/180))),pwl(ds_5_phase,beamID)*1deg)
  6:1: if(UseBeamPair,mag(pwl(ds_6_mag,beamID)*exp(cmplx(0,pwl(ds_6_phase,beamID)*pi/180))+pwl(ds_6_mag_bp,beamID)*exp(cmplx(0,BeamPair_PhaseOffset*pi/180deg+pwl(ds_6_phase_bp,beamID)*pi/180))),pwl(ds_6_mag,beamID)) 180deg/pi*if(UseBeamPair,ang_deg(pwl(ds_6_mag,beamID)*exp(cmplx(0,pwl(ds_6_phase,beamID)*pi/180))+pwl(ds_6_mag_bp,beamID)*exp(cmplx(0,BeamPair_PhaseOffset*pi/180deg+pwl(ds_6_phase_bp,beamID)*pi/180))),pwl(ds_6_phase,beamID)*1deg)
  7:1: if(UseBeamPair,mag(pwl(ds_7_mag,beamID)*exp(cmplx(0,pwl(ds_7_phase,beamID)*pi/180))+pwl(ds_7_mag_bp,beamID)*exp(cmplx(0,BeamPair_PhaseOffset*pi/180deg+pwl(ds_7_phase_bp,beamID)*pi/180))),pwl(ds_7_mag,beamID)) 180deg/pi*if(UseBeamPair,ang_deg(pwl(ds_7_mag,beamID)*exp(cmplx(0,pwl(ds_7_phase,beamID)*pi/180))+pwl(ds_7_mag_bp,beamID)*exp(cmplx(0,BeamPair_PhaseOffset*pi/180deg+pwl(ds_7_phase_bp,beamID)*pi/180))),pwl(ds_7_phase,beamID)*1deg)
  8:1: if(UseBeamPair,mag(pwl(ds_8_mag,beamID)*exp(cmplx(0,pwl(ds_8_phase,beamID)*pi/180))+pwl(ds_8_mag_bp,beamID)*exp(cmplx(0,BeamPair_PhaseOffset*pi/180deg+pwl(ds_8_phase_bp,beamID)*pi/180))),pwl(ds_8_mag,beamID)) 180deg/pi*if(UseBeamPair,ang_deg(pwl(ds_8_mag,beamID)*exp(cmplx(0,pwl(ds_8_phase,beamID)*pi/180))+pwl(ds_8_mag_bp,beamID)*exp(cmplx(0,BeamPair_PhaseOffset*pi/180deg+pwl(ds_8_phase_bp,beamID)*pi/180))),pwl(ds_8_phase,beamID)*1deg)
radiation setups:
  3D: Infinite Sphere Theta=-180deg..180deg step 2deg Phi=0deg..180deg step 2deg
  Elevation: Infinite Sphere Theta=-180deg..180deg step 1deg Phi=0deg..90deg step 90deg
  Azimuth: Infinite Sphere Theta=90deg..90deg step 0deg Phi=-180deg..180deg step 1deg
output variables:
  Prad = 10*log10(AcceptedPower/1e-3)
field calculator expressions:
  Pz = Fundamental_Quantity(0) | <Hx,Hy,Hz> | Conj | Cross | 0.5 | * | ScalarZ | Real
reports:
  CDF: max(dB(RealizedGainTotal)) vs Freq on Setup1 : LastAdaptive, 3D [beamID=all Freq=28GHz Phi=all Theta=all]
  EnvelopePattern3D_F_28.0GHz: max(dB(RealizedGainTotal)) vs Theta, Phi on Setup1 : LastAdaptive, 3D [beamID=all Freq=28GHz]
  BeamID_for_Max_F_28.0GHz: XAtYMax(dB(RealizedGainTotal)) vs Theta, Phi on Setup1 : LastAdaptive, 3D [beamID=all Freq=28GHz]
